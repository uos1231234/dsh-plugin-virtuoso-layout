* LVS for DSH_NMOS/dsh_nmos13: NMOS with a P+ guard ring (no N-well).
* The ring is the body/substrate tie, tied to B.
.subckt dsh_nmos13 D G S B
MN1 D G S B <model> w=1.2u l=0.18u
.ends dsh_nmos13
